# Ansys Electronics Desktop project, version 2022.2
materials:
  vacuum: permittivity=1
  N36Z_20: permeability=1.03 magnetic_coercivity{Magnitude=-920000A_per_meter DirComp1=1 DirComp2=0 DirComp3=0}
  M19_29G: permeability{HUnit=A_per_meter BUnit=tesla curve (0, 0) (22.28, 0.05) (25.46, 0.1) (31.83, 0.15) (47.74, 0.36) (63.66, 0.54) (79.57, 0.65) (159.15, 0.99) (318.3, 1.2) (477.46, 1.28) (636.61, 1.33) (795.77, 1.36) (1591.5, 1.44) (3183, 1.52) (4774.6, 1.58) (6366.1, 1.63) (7957.7, 1.67) (15915, 1.8) (31830, 1.9) (111407, 2) (190984, 2.1) (350138, 2.3) (509252, 2.5) (560177.2, 2.563994494) (1527756, 3.779889874)}

design 1_Whole_Motor (Maxwell 2D, Transient, XY geometry, model units mm)
options: ModelDepth=1meter
geometry:
  Stator [vacuum] = user_primitive(RMxprt/SlotCore.dll, DiaGap=161.9mm, DiaYoke=269.24mm, Length=0mm, Skew=0deg, Slots=48, SlotType=2, Hs0=1.03mm, Hs01=0mm, Hs1=0mm, Hs2=29.5mm, Bs0=1.93mm, Bs1=5mm, Bs2=8mm, Rs=0mm, FilletType=0, HalfSlot=0, SegAngle=0deg, LenRegion=200mm, InfoCore=0)
  Rotor [vacuum] = user_primitive(RMxprt/IPMCore.dll, DiaGap=160.4mm, DiaYoke=110.64mm, Length=0mm, Poles=8, PoleType=3, D1=157.44mm, O1=3mm, O2=7.28mm, B1=4.7mm, Rib=14mm, HRib=3mm, DminMag=4.5mm, ThickMag=6.48mm, WidthMag=32mm, LenRegion=200mm, InfoCore=0)
  Magnet [vacuum] = user_primitive(RMxprt/IPMCore.dll, DiaGap=160.4mm, DiaYoke=110.64mm, Length=0mm, Poles=8, PoleType=3, D1=157.44mm, O1=3mm, O2=7.28mm, B1=4.7mm, Rib=14mm, HRib=3mm, DminMag=4.5mm, ThickMag=6.48mm, WidthMag=32mm, LenRegion=200mm, InfoCore=1)
  PhaseA [vacuum] = user_primitive(RMxprt/LapCoil.dll, DiaGap=161.9mm, DiaYoke=269.24mm, Length=0mm, Skew=0deg, Slots=48, SlotType=2, Hs0=1.28mm, Hs1=0.1mm, Hs2=29.7mm, Bs0=2.11mm, Bs1=3.14mm, Bs2=5.65mm, Rs=2.5mm, FilletType=0, Layers=1, CoilPitch=5, EndExt=5mm, SpanExt=18mm, BendAngle=0deg, SegAngle=10deg, LenRegion=200mm, InfoCoil=1)
  PhaseA.rotate(axis=Z, angle=7.5deg)
  PhaseB, PhaseC [vacuum] = PhaseA.duplicate_around_axis(axis=Z, angle=15deg, total=3)
  PhaseA_1..PhaseA_7 [vacuum] = PhaseA.duplicate_around_axis(axis=Z, angle=45deg, total=8)
  PhaseB_1..PhaseB_7 [vacuum] = PhaseB.duplicate_around_axis(axis=Z, angle=45deg, total=8)
  PhaseC_1..PhaseC_7 [vacuum] = PhaseC.duplicate_around_axis(axis=Z, angle=45deg, total=8)
mesh:
  initial mesh: MeshMethod=AnsoftTAU

design 2_Partial_Motor (Maxwell 2D, Transient, XY geometry, model units mm)
options: ModelDepth=1meter
geometry:
  Stator [M19_29G] = user_primitive(RMxprt/SlotCore.dll, DiaGap=161.9mm, DiaYoke=269.24mm, Length=0mm, Skew=0deg, Slots=48, SlotType=2, Hs0=1.03mm, Hs01=0mm, Hs1=0mm, Hs2=29.5mm, Bs0=1.93mm, Bs1=5mm, Bs2=8mm, Rs=0mm, FilletType=0, HalfSlot=0, SegAngle=0deg, LenRegion=200mm, InfoCore=0)
  Rotor [M19_29G] = user_primitive(RMxprt/IPMCore.dll, DiaGap=160.4mm, DiaYoke=110.64mm, Length=0mm, Poles=8, PoleType=3, D1=157.44mm, O1=3mm, O2=7.28mm, B1=4.7mm, Rib=14mm, HRib=3mm, DminMag=4.5mm, ThickMag=6.48mm, WidthMag=32mm, LenRegion=200mm, InfoCore=0)
  PM1 [N36Z_20, oriented by PM1_CS] = user_primitive(RMxprt/IPMCore.dll, DiaGap=160.4mm, DiaYoke=110.64mm, Length=0mm, Poles=8, PoleType=3, D1=157.44mm, O1=3mm, O2=7.28mm, B1=4.7mm, Rib=14mm, HRib=3mm, DminMag=4.5mm, ThickMag=6.48mm, WidthMag=32mm, LenRegion=200mm, InfoCore=1)
  PhaseA1 [vacuum] = user_primitive(RMxprt/LapCoil.dll, DiaGap=161.9mm, DiaYoke=269.24mm, Length=0mm, Skew=0deg, Slots=48, SlotType=2, Hs0=1.28mm, Hs1=0.1mm, Hs2=29.7mm, Bs0=2.11mm, Bs1=3.14mm, Bs2=5.65mm, Rs=2.5mm, FilletType=0, Layers=1, CoilPitch=5, EndExt=5mm, SpanExt=18mm, BendAngle=0deg, SegAngle=10deg, LenRegion=200mm, InfoCoil=1)
  PhaseA1.rotate(axis=Z, angle=7.5deg)
  PhaseB1, PhaseC1 [vacuum] = PhaseA1.duplicate_around_axis(axis=Z, angle=15deg, total=3)
  PhaseA2 [vacuum] = PhaseA1.duplicate_around_axis(axis=Z, angle=45deg, total=8)  # copies kept: 7
  PhaseB2 [vacuum] = PhaseB1.duplicate_around_axis(axis=Z, angle=45deg, total=8)  # copies kept: 7
  PhaseC2 [vacuum] = PhaseC1.duplicate_around_axis(axis=Z, angle=45deg, total=8)  # copies kept: 7
  [Stator, Rotor, PM1, PhaseA1, PhaseB1, PhaseC1, PhaseA2, PhaseB2, PhaseC2].split(plane=ZX, keep=PositiveOnly)
  [Stator, Rotor, PM1, PhaseA1, PhaseB1, PhaseC1, PhaseA2, PhaseB2, PhaseC2].rotate(axis=Z, angle=-45deg)
  [Stator, Rotor, PM1, PhaseA1, PhaseB1, PhaseC1, PhaseA2, PhaseB2, PhaseC2].split(plane=ZX, keep=NegativeOnly)
  [Stator, Rotor, PM1, PhaseA1, PhaseB1, PhaseC1, PhaseA2, PhaseB2, PhaseC2].rotate(axis=Z, angle=45deg)
  Region [vacuum] = polyline((0mm, 0mm, 0mm) (200mm, 0mm, 0mm))
  Region.sweep_around_axis(axis=Z, angle=45deg, segments=5)
  PM2 [N36Z_20, oriented by PM2_CS] = PM1.separate_bodies()
  coordinate_system PM1_CS = face of PM1: Origin=(64.799739, 41.119197, 0) FaceID=PM1.face(7 of 16) AxisPosn=(62.589074, 35.027944, 0) WhichAxis=X ZRotationAngle=0deg XOffset=0mm YOffset=0mm
  coordinate_system PM2_CS = face of PM2: Origin=(69.025655, 19.488662, 0) FaceID=PM1.face(16 of 16) AxisPosn=(74.895998, 16.744672, 0) WhichAxis=X ZRotationAngle=0deg XOffset=0mm YOffset=0mm
mesh:
  initial mesh: MeshMethod=AnsoftTAU
