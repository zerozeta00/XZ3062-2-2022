# Ansys Electronics Desktop project, version 2022.2
materials:
  vacuum: permittivity=1
  N36Z_20: permeability=1.03 magnetic_coercivity{Magnitude=-920000A_per_meter DirComp1=1 DirComp2=0 DirComp3=0}
  M19_29G: core_loss_curve{50Hz (0, 0) (0.1, 0.03) (0.2, 0.07) (0.3, 0.13) (0.4, 0.22) (0.5, 0.31) (0.6, 0.43) (0.7, 0.54) (0.8, 0.68) (0.9, 0.83) (1, 1.01) (1.1, 1.2) (1.2, 1.42) (1.3, 1.7) (1.4, 2.12) (1.5, 2.47) (1.6, 2.8) (1.7, 3.05) (1.8, 3.25)} core_loss_curve{100Hz (0, 0) (0.1, 0.14) (0.2, 0.16) (0.3, 0.34) (0.4, 0.55) (0.5, 0.8) (0.6, 1.08) (0.7, 1.38) (0.8, 1.73) (0.9, 2.1) (1, 2.51) (1.1, 2.98) (1.2, 3.51) (1.3, 4.15) (1.4, 4.97) (1.5, 5.92)} core_loss_curve{200Hz (0, 0) (0.1, 0.09) (0.2, 0.37) (0.3, 0.79) (0.4, 1.31) (0.5, 1.91) (0.6, 2.61) (0.7, 3.39) (0.8, 4.26) (0.9, 5.23) (1, 6.3) (1.1, 7.51) (1.2, 8.88) (1.3, 10.5) (1.4, 12.5) (1.5, 14.9)} core_loss_curve{400Hz (0, 0) (0.1, 0.21) (0.2, 0.92) (0.3, 1.99) (0.4, 3.33) (0.5, 4.94) (0.6, 6.84) (0.7, 9) (0.8, 11.4) (0.9, 14.2) (1, 17.3) (1.1, 20.9) (1.2, 24.9) (1.3, 29.5) (1.4, 35.4) (1.5, 41.8)} core_loss_curve{1000Hz (0, 0) (0.1, 0.99) (0.2, 3.67) (0.3, 7.63) (0.4, 12.7) (0.5, 18.9) (0.6, 26.4) (0.7, 35.4) (0.8, 46) (0.9, 58.4) (1, 73) (1.1, 90.1)} permeability{HUnit=A_per_meter BUnit=tesla curve (0, 0) (22.28, 0.05) (25.46, 0.1) (31.83, 0.15) (47.74, 0.36) (63.66, 0.54) (79.57, 0.65) (159.15, 0.99) (318.3, 1.2) (477.46, 1.28) (636.61, 1.33) (795.77, 1.36) (1591.5, 1.44) (3183, 1.52) (4774.6, 1.58) (6366.1, 1.63) (7957.7, 1.67) (15915, 1.8) (31830, 1.9) (111407, 2) (190984, 2.1) (350138, 2.3) (509252, 2.5) (560177.2, 2.563994494) (1527756, 3.779889874)} core_loss_type="Electrical Steel" core_loss_kh=0.023403484 core_loss_kc=4.9066776e-05 core_loss_ke=3.4360289e-05 magnetostriction{PropertyModelType=0 Dir1ModelType=0 Dir2ModelType=0 IsoCoeff=0 IsoHMax=0A_per_meter IsoHMin=0A_per_meter Dir1Coeff=0 Dir1HMax=0A_per_meter Dir1HMin=0A_per_meter Dir1VecX=1 Dir1VecY=0 Dir1VecZ=0 Dir2Coeff=0 Dir2HMax=0A_per_meter Dir2HMin=0A_per_meter Magnetostriction{Isotropic{OneVariation{DatasetMapsName="Lambda-H curves versus Stress"}} Direction1{OneVariation{DatasetMapsName="Lambda-H curves versus Stress"}} Direction2{OneVariation{DatasetMapsName="Lambda-H curves versus Stress"}} SelectedDatasetMapsName="Lambda-H curves versus Stress"}} inverse_magnetostriction{PropertyModelType=0 Dir1ModelType=0 IsoCoeff=0 IsoSigmaMax=0megPascal IsoSigmaMin=0megPascal Dir1Coeff=0 Dir1SigmaMax=0megPascal Dir1SigmaMin=0megPascal Dir1VecX=1 Dir1VecY=0 Dir1VecZ=0 Magnetostriction{Isotropic{OneVariation{DatasetMapsName="B-H curves versus Stress"} OneVariation{DatasetMapsName="B-Sigma curves versus H"}} Direction1{OneVariation{DatasetMapsName="B-H curves versus Stress"} OneVariation{DatasetMapsName="B-Sigma curves versus H"}} SelectedDatasetMapsName="B-H curves versus Stress"}} core_loss_equiv_cut_depth=0.001meter

design 1_Whole_Motor (Maxwell 2D, Transient, XY geometry, model units mm)
options: ModelDepth=1meter
geometry:
  Stator [vacuum] = user_primitive(RMxprt/SlotCore.dll, DiaGap=161.9mm, DiaYoke=269.24mm, Length=0mm, Skew=0deg, Slots=48, SlotType=2, Hs0=1.03mm, Hs01=0mm, Hs1=0mm, Hs2=29.5mm, Bs0=1.93mm, Bs1=5mm, Bs2=8mm, Rs=0mm, FilletType=0, HalfSlot=0, SegAngle=0deg, LenRegion=200mm, InfoCore=0)
  Rotor [vacuum] = user_primitive(RMxprt/IPMCore.dll, DiaGap=160.4mm, DiaYoke=110.64mm, Length=0mm, Poles=8, PoleType=3, D1=157.44mm, O1=3mm, O2=7.28mm, B1=4.7mm, Rib=14mm, HRib=3mm, DminMag=4.5mm, ThickMag=6.48mm, WidthMag=32mm, LenRegion=200mm, InfoCore=0)
  Magnet [vacuum] = user_primitive(RMxprt/IPMCore.dll, DiaGap=160.4mm, DiaYoke=110.64mm, Length=0mm, Poles=8, PoleType=3, D1=157.44mm, O1=3mm, O2=7.28mm, B1=4.7mm, Rib=14mm, HRib=3mm, DminMag=4.5mm, ThickMag=6.48mm, WidthMag=32mm, LenRegion=200mm, InfoCore=1)
  PhaseA [vacuum] = user_primitive(RMxprt/LapCoil.dll, DiaGap=161.9mm, DiaYoke=269.24mm, Length=0mm, Skew=0deg, Slots=48, SlotType=2, Hs0=1.28mm, Hs1=0.1mm, Hs2=29.7mm, Bs0=2.11mm, Bs1=3.14mm, Bs2=5.65mm, Rs=2.5mm, FilletType=0, Layers=1, CoilPitch=5, EndExt=5mm, SpanExt=18mm, BendAngle=0deg, SegAngle=10deg, LenRegion=200mm, InfoCoil=1)
  PhaseA.rotate(axis=Z, angle=7.5deg)
  PhaseB, PhaseC [vacuum] = PhaseA.duplicate_around_axis(axis=Z, angle=15deg, total=3)
  PhaseA_1..PhaseA_7 [vacuum] = PhaseA.duplicate_around_axis(axis=Z, angle=45deg, total=8)
  PhaseB_1..PhaseB_7 [vacuum] = PhaseB.duplicate_around_axis(axis=Z, angle=45deg, total=8)
  PhaseC_1..PhaseC_7 [vacuum] = PhaseC.duplicate_around_axis(axis=Z, angle=45deg, total=8)
mesh:
  initial mesh: MeshMethod=AnsoftTAU

design 2_Partial_Motor (Maxwell 2D, Transient, XY geometry, model units mm)
options: ModelDepth=1meter
geometry:
  Stator [M19_29G] = user_primitive(RMxprt/SlotCore.dll, DiaGap=161.9mm, DiaYoke=269.24mm, Length=0mm, Skew=0deg, Slots=48, SlotType=2, Hs0=1.03mm, Hs01=0mm, Hs1=0mm, Hs2=29.5mm, Bs0=1.93mm, Bs1=5mm, Bs2=8mm, Rs=0mm, FilletType=0, HalfSlot=0, SegAngle=0deg, LenRegion=200mm, InfoCore=0)
  Rotor [M19_29G] = user_primitive(RMxprt/IPMCore.dll, DiaGap=160.4mm, DiaYoke=110.64mm, Length=0mm, Poles=8, PoleType=3, D1=157.44mm, O1=3mm, O2=7.28mm, B1=4.7mm, Rib=14mm, HRib=3mm, DminMag=4.5mm, ThickMag=6.48mm, WidthMag=32mm, LenRegion=200mm, InfoCore=0)
  PM1 [N36Z_20, oriented by PM1_CS] = user_primitive(RMxprt/IPMCore.dll, DiaGap=160.4mm, DiaYoke=110.64mm, Length=0mm, Poles=8, PoleType=3, D1=157.44mm, O1=3mm, O2=7.28mm, B1=4.7mm, Rib=14mm, HRib=3mm, DminMag=4.5mm, ThickMag=6.48mm, WidthMag=32mm, LenRegion=200mm, InfoCore=1)
  PhaseA1 [vacuum] = user_primitive(RMxprt/LapCoil.dll, DiaGap=161.9mm, DiaYoke=269.24mm, Length=0mm, Skew=0deg, Slots=48, SlotType=2, Hs0=1.28mm, Hs1=0.1mm, Hs2=29.7mm, Bs0=2.11mm, Bs1=3.14mm, Bs2=5.65mm, Rs=2.5mm, FilletType=0, Layers=1, CoilPitch=5, EndExt=5mm, SpanExt=18mm, BendAngle=0deg, SegAngle=10deg, LenRegion=200mm, InfoCoil=1)
  PhaseA1.rotate(axis=Z, angle=7.5deg)
  PhaseB1, PhaseC1 [vacuum] = PhaseA1.duplicate_around_axis(axis=Z, angle=15deg, total=3)
  PhaseA2 [vacuum] = PhaseA1.duplicate_around_axis(axis=Z, angle=45deg, total=8)  # copies kept: 7
  PhaseB2 [vacuum] = PhaseB1.duplicate_around_axis(axis=Z, angle=45deg, total=8)  # copies kept: 7
  PhaseC2 [vacuum] = PhaseC1.duplicate_around_axis(axis=Z, angle=45deg, total=8)  # copies kept: 7
  [Stator, Rotor, PM1, PhaseA1, PhaseB1, PhaseC1, PhaseA2, PhaseB2, PhaseC2].split(plane=ZX, keep=PositiveOnly)
  [Stator, Rotor, PM1, PhaseA1, PhaseB1, PhaseC1, PhaseA2, PhaseB2, PhaseC2].rotate(axis=Z, angle=-45deg)
  [Stator, Rotor, PM1, PhaseA1, PhaseB1, PhaseC1, PhaseA2, PhaseB2, PhaseC2].split(plane=ZX, keep=NegativeOnly)
  [Stator, Rotor, PM1, PhaseA1, PhaseB1, PhaseC1, PhaseA2, PhaseB2, PhaseC2].rotate(axis=Z, angle=45deg)
  Region [vacuum] = polyline((0mm, 0mm, 0mm) (200mm, 0mm, 0mm))
  Region.sweep_around_axis(axis=Z, angle=45deg, segments=5)
  PM2 [N36Z_20, oriented by PM2_CS] = PM1.separate_bodies()
  coordinate_system PM1_CS = face of PM1: Origin=(64.799739, 41.119197, 0) FaceID=PM1.face(7 of 16) AxisPosn=(62.589074, 35.027944, 0) WhichAxis=X ZRotationAngle=0deg XOffset=0mm YOffset=0mm
  coordinate_system PM2_CS = face of PM2: Origin=(69.025655, 19.488662, 0) FaceID=PM1.face(16 of 16) AxisPosn=(74.895998, 16.744672, 0) WhichAxis=X ZRotationAngle=0deg XOffset=0mm YOffset=0mm
boundaries and excitations:
  Independent1: Independent Edges=Region.edge(1 of 1)
  Dependent1: Dependent Edges=Region.edge(#2142) ReverseU Independent=Independent1 SameAsMaster=false
  Zero_Flux: Vector Potential Edges=Region.edge(#2136, #2137, #2138, #2139, #2140, #2141) Value=0
mesh:
  initial mesh: MeshMethod=AnsoftTAU

design 3_Partial_Motor_MS (Maxwell 2D, Magnetostatic, XY geometry, model units mm)
options: ModelDepth=1meter
geometry:
  Stator [M19_29G] = user_primitive(RMxprt/SlotCore.dll, DiaGap=161.9mm, DiaYoke=269.24mm, Length=0mm, Skew=0deg, Slots=48, SlotType=2, Hs0=1.03mm, Hs01=0mm, Hs1=0mm, Hs2=29.5mm, Bs0=1.93mm, Bs1=5mm, Bs2=8mm, Rs=0mm, FilletType=0, HalfSlot=0, SegAngle=0deg, LenRegion=200mm, InfoCore=0)
  Rotor [M19_29G] = user_primitive(RMxprt/IPMCore.dll, DiaGap=160.4mm, DiaYoke=110.64mm, Length=0mm, Poles=8, PoleType=3, D1=157.44mm, O1=3mm, O2=7.28mm, B1=4.7mm, Rib=14mm, HRib=3mm, DminMag=4.5mm, ThickMag=6.48mm, WidthMag=32mm, LenRegion=200mm, InfoCore=0)
  PM1 [N36Z_20, oriented by PM1_CS] = user_primitive(RMxprt/IPMCore.dll, DiaGap=160.4mm, DiaYoke=110.64mm, Length=0mm, Poles=8, PoleType=3, D1=157.44mm, O1=3mm, O2=7.28mm, B1=4.7mm, Rib=14mm, HRib=3mm, DminMag=4.5mm, ThickMag=6.48mm, WidthMag=32mm, LenRegion=200mm, InfoCore=1)
  PhaseA1 [vacuum, non-model] = user_primitive(RMxprt/LapCoil.dll, DiaGap=161.9mm, DiaYoke=269.24mm, Length=0mm, Skew=0deg, Slots=48, SlotType=2, Hs0=1.28mm, Hs1=0.1mm, Hs2=29.7mm, Bs0=2.11mm, Bs1=3.14mm, Bs2=5.65mm, Rs=2.5mm, FilletType=0, Layers=1, CoilPitch=5, EndExt=5mm, SpanExt=18mm, BendAngle=0deg, SegAngle=10deg, LenRegion=200mm, InfoCoil=1)
  PhaseA1.rotate(axis=Z, angle=7.5deg)
  PhaseB1, PhaseC1 [vacuum, non-model] = PhaseA1.duplicate_around_axis(axis=Z, angle=15deg, total=3)
  PhaseA2 [vacuum, non-model] = PhaseA1.duplicate_around_axis(axis=Z, angle=45deg, total=8)  # copies kept: 7
  PhaseB2 [vacuum, non-model] = PhaseB1.duplicate_around_axis(axis=Z, angle=45deg, total=8)  # copies kept: 7
  PhaseC2 [vacuum, non-model] = PhaseC1.duplicate_around_axis(axis=Z, angle=45deg, total=8)  # copies kept: 7
  [Stator, Rotor, PM1, PhaseA1, PhaseB1, PhaseC1, PhaseA2, PhaseB2, PhaseC2].split(plane=ZX, keep=PositiveOnly)
  [Stator, Rotor, PM1, PhaseA1, PhaseB1, PhaseC1, PhaseA2, PhaseB2, PhaseC2].rotate(axis=Z, angle=-45deg)
  [Stator, Rotor, PM1, PhaseA1, PhaseB1, PhaseC1, PhaseA2, PhaseB2, PhaseC2].split(plane=ZX, keep=NegativeOnly)
  [Stator, Rotor, PM1, PhaseA1, PhaseB1, PhaseC1, PhaseA2, PhaseB2, PhaseC2].rotate(axis=Z, angle=45deg)
  Region [vacuum] = polyline((0mm, 0mm, 0mm) (200mm, 0mm, 0mm))
  Region.sweep_around_axis(axis=Z, angle=45deg, segments=5)
  PM2 [N36Z_20, oriented by PM2_CS] = PM1.separate_bodies()
  coordinate_system PM1_CS = face of PM1: Origin=(64.799739, 41.119197, 0) FaceID=PM1.face(7 of 16) AxisPosn=(62.589074, 35.027944, 0) WhichAxis=X ZRotationAngle=0deg XOffset=0mm YOffset=0mm
  coordinate_system PM2_CS = face of PM2: Origin=(69.025655, 19.488662, 0) FaceID=PM1.face(16 of 16) AxisPosn=(74.895998, 16.744672, 0) WhichAxis=X ZRotationAngle=0deg XOffset=0mm YOffset=0mm
  airgap_arc [non-model] = polyline(z=0mm, xy in mm: (80.575, 0) (74.441593, 30.834718) (56.975129, 56.975129), AngularArc from point 0 over 3 centre=(0mm, 0mm, 0mm) angle=45deg plane=XY)
boundaries and excitations:
  Independent1: Independent Edges=Region.edge(1 of 1)
  Dependent1: Dependent Edges=Region.edge(#2142) ReverseU Independent=Independent1 SameAsMaster=false
  Zero_Flux: Vector Potential Edges=Region.edge(#2136, #2137, #2138, #2139, #2140, #2141) Value=0
parameters:
  Torque1: Torque Coordinate_System=Global Is_Positive=true Objects=[PM1, PM2, Rotor]
mesh:
  Rotor: LengthBased RefineInside Objects=Rotor MaxLength=5mm
  Magnets: LengthBased RefineInside Objects=[PM1, PM2] MaxLength=3mm
  SA_Stator: SurfApproxBased Objects=Stator CurvedSurfaceApproxChoice=ManualSettings NormalDev=30deg AspectRatio=5
  initial mesh: MeshMethod=AnsoftTAU
setups:
  Setup1: Magnetostatic MaximumPasses=10 MinimumPasses=2 MinimumConvergedPasses=1 PercentRefinement=15 PercentError=0.1 NonLinearResidual=0.0001

design 4_Partial_Motor_MS2 (Maxwell 2D, Magnetostatic, XY geometry, model units mm)
options: ModelDepth=1meter
geometry:
  Stator [M19_29G] = user_primitive(RMxprt/SlotCore.dll, DiaGap=161.9mm, DiaYoke=269.24mm, Length=0mm, Skew=0deg, Slots=48, SlotType=2, Hs0=1.03mm, Hs01=0mm, Hs1=0mm, Hs2=29.5mm, Bs0=1.93mm, Bs1=5mm, Bs2=8mm, Rs=0mm, FilletType=0, HalfSlot=0, SegAngle=0deg, LenRegion=200mm, InfoCore=0)
  Rotor [M19_29G] = user_primitive(RMxprt/IPMCore.dll, DiaGap=160.4mm, DiaYoke=110.64mm, Length=0mm, Poles=8, PoleType=3, D1=157.44mm, O1=3mm, O2=7.28mm, B1=4.7mm, Rib=14mm, HRib=3mm, DminMag=4.5mm, ThickMag=6.48mm, WidthMag=32mm, LenRegion=200mm, InfoCore=0)
  PM1 [N36Z_20, oriented by PM1_CS] = user_primitive(RMxprt/IPMCore.dll, DiaGap=160.4mm, DiaYoke=110.64mm, Length=0mm, Poles=8, PoleType=3, D1=157.44mm, O1=3mm, O2=7.28mm, B1=4.7mm, Rib=14mm, HRib=3mm, DminMag=4.5mm, ThickMag=6.48mm, WidthMag=32mm, LenRegion=200mm, InfoCore=1)
  PhaseA1 [vacuum] = user_primitive(RMxprt/LapCoil.dll, DiaGap=161.9mm, DiaYoke=269.24mm, Length=0mm, Skew=0deg, Slots=48, SlotType=2, Hs0=1.28mm, Hs1=0.1mm, Hs2=29.7mm, Bs0=2.11mm, Bs1=3.14mm, Bs2=5.65mm, Rs=2.5mm, FilletType=0, Layers=1, CoilPitch=5, EndExt=5mm, SpanExt=18mm, BendAngle=0deg, SegAngle=10deg, LenRegion=200mm, InfoCoil=1)
  PhaseA1.rotate(axis=Z, angle=7.5deg)
  PhaseB1, PhaseC1 [vacuum] = PhaseA1.duplicate_around_axis(axis=Z, angle=15deg, total=3)
  PhaseA2 [vacuum] = PhaseA1.duplicate_around_axis(axis=Z, angle=45deg, total=8)  # copies kept: 7
  PhaseB2 [vacuum] = PhaseB1.duplicate_around_axis(axis=Z, angle=45deg, total=8)  # copies kept: 7
  PhaseC2 [vacuum] = PhaseC1.duplicate_around_axis(axis=Z, angle=45deg, total=8)  # copies kept: 7
  [Stator, Rotor, PM1, PhaseA1, PhaseB1, PhaseC1, PhaseA2, PhaseB2, PhaseC2].split(plane=ZX, keep=PositiveOnly)
  [Stator, Rotor, PM1, PhaseA1, PhaseB1, PhaseC1, PhaseA2, PhaseB2, PhaseC2].rotate(axis=Z, angle=-45deg)
  [Stator, Rotor, PM1, PhaseA1, PhaseB1, PhaseC1, PhaseA2, PhaseB2, PhaseC2].split(plane=ZX, keep=NegativeOnly)
  [Stator, Rotor, PM1, PhaseA1, PhaseB1, PhaseC1, PhaseA2, PhaseB2, PhaseC2].rotate(axis=Z, angle=45deg)
  Region [vacuum] = polyline((0mm, 0mm, 0mm) (200mm, 0mm, 0mm))
  Region.sweep_around_axis(axis=Z, angle=45deg, segments=5)
  PM2 [N36Z_20, oriented by PM2_CS] = PM1.separate_bodies()
  coordinate_system PM1_CS = face of PM1: Origin=(64.799739, 41.119197, 0) FaceID=PM1.face(7 of 16) AxisPosn=(62.589074, 35.027944, 0) WhichAxis=X ZRotationAngle=0deg XOffset=0mm YOffset=0mm
  coordinate_system PM2_CS = face of PM2: Origin=(69.025655, 19.488662, 0) FaceID=PM1.face(16 of 16) AxisPosn=(74.895998, 16.744672, 0) WhichAxis=X ZRotationAngle=0deg XOffset=0mm YOffset=0mm
  airgap_arc [non-model] = polyline(z=0mm, xy in mm: (80.575, 0) (74.441593, 30.834718) (56.975129, 56.975129), AngularArc from point 0 over 3 centre=(0mm, 0mm, 0mm) angle=45deg plane=XY)
boundaries and excitations:
  Independent1: Independent Edges=Region.edge(1 of 1)
  Dependent1: Dependent Edges=Region.edge(#2142) ReverseU Independent=Independent1 SameAsMaster=false
  Zero_Flux: Vector Potential Edges=Region.edge(#2136, #2137, #2138, #2139, #2140, #2141) Value=0
  PhaseA_1: Current Objects=PhaseA1 Current=1500A IsPositive=true
  PhaseA_2: Current Objects=PhaseA2 Current=1500A IsPositive=true
  PhaseC_1: Current Objects=PhaseC1 Current=-750A IsPositive=false
  PhaseC_2: Current Objects=PhaseC2 Current=-750A IsPositive=false
  PhaseB_1: Current Objects=PhaseB1 Current=-750A IsPositive=true
  PhaseB_2: Current Objects=PhaseB2 Current=-750A IsPositive=true
parameters:
  Torque1: Torque Coordinate_System=Global Is_Positive=true Objects=[PM1, PM2, Rotor]
  Matrix1: Matrix PhaseA_1, PhaseA_2, PhaseB_1, PhaseB_2, PhaseC_1, PhaseC_2: NumberOfTurns=9; group PhaseA = PhaseA_1, PhaseA_2 (1 parallel); group PhaseB = PhaseB_1, PhaseB_2 (1 parallel); group PhaseC = PhaseC_1, PhaseC_2 (1 parallel)
mesh:
  Rotor: LengthBased RefineInside Objects=Rotor MaxLength=5mm
  Magnets: LengthBased RefineInside Objects=[PM1, PM2] MaxLength=3mm
  SA_Stator: SurfApproxBased Objects=Stator CurvedSurfaceApproxChoice=ManualSettings NormalDev=30deg AspectRatio=5
  initial mesh: MeshMethod=AnsoftTAU
setups:
  Setup1: Magnetostatic MaximumPasses=10 MinimumPasses=2 MinimumConvergedPasses=1 PercentRefinement=15 PercentError=0.1 NonLinearResidual=0.0001
field plots:
  H_Vector1: H over a plane on Setup1 : LastAdaptive

design 5_Partial_Motor_TR (Maxwell 2D, Transient, XY geometry, model units mm)
options: PreserveTranSolnAfterDatasetEdit ModelDepth=83.82mm
variables:
  Poles = 8
  PolePairs = Poles/2
  Speed_rpm = 3000
  Omega = 360*Speed_rpm*PolePairs/60
  Omega_rad = Omega*pi/180
  Thet_deg = 20
  Thet = Thet_deg*pi/180
  Imax = 250A
geometry:
  Stator [M19_29G] = user_primitive(RMxprt/SlotCore.dll, DiaGap=161.9mm, DiaYoke=269.24mm, Length=0mm, Skew=0deg, Slots=48, SlotType=2, Hs0=1.03mm, Hs01=0mm, Hs1=0mm, Hs2=29.5mm, Bs0=1.93mm, Bs1=5mm, Bs2=8mm, Rs=0mm, FilletType=0, HalfSlot=0, SegAngle=0deg, LenRegion=200mm, InfoCore=0)
  Rotor [M19_29G] = user_primitive(RMxprt/IPMCore.dll, DiaGap=160.4mm, DiaYoke=110.64mm, Length=0mm, Poles=8, PoleType=3, D1=157.44mm, O1=3mm, O2=7.28mm, B1=4.7mm, Rib=14mm, HRib=3mm, DminMag=4.5mm, ThickMag=6.48mm, WidthMag=32mm, LenRegion=200mm, InfoCore=0)
  PM1 [N36Z_20, oriented by PM1_CS] = user_primitive(RMxprt/IPMCore.dll, DiaGap=160.4mm, DiaYoke=110.64mm, Length=0mm, Poles=8, PoleType=3, D1=157.44mm, O1=3mm, O2=7.28mm, B1=4.7mm, Rib=14mm, HRib=3mm, DminMag=4.5mm, ThickMag=6.48mm, WidthMag=32mm, LenRegion=200mm, InfoCore=1)
  PhaseA1 [vacuum] = user_primitive(RMxprt/LapCoil.dll, DiaGap=161.9mm, DiaYoke=269.24mm, Length=0mm, Skew=0deg, Slots=48, SlotType=2, Hs0=1.28mm, Hs1=0.1mm, Hs2=29.7mm, Bs0=2.11mm, Bs1=3.14mm, Bs2=5.65mm, Rs=2.5mm, FilletType=0, Layers=1, CoilPitch=5, EndExt=5mm, SpanExt=18mm, BendAngle=0deg, SegAngle=10deg, LenRegion=200mm, InfoCoil=1)
  PhaseA1.rotate(axis=Z, angle=7.5deg)
  PhaseB1, PhaseC1 [vacuum] = PhaseA1.duplicate_around_axis(axis=Z, angle=15deg, total=3)
  PhaseA2 [vacuum] = PhaseA1.duplicate_around_axis(axis=Z, angle=45deg, total=8)  # copies kept: 7
  PhaseB2 [vacuum] = PhaseB1.duplicate_around_axis(axis=Z, angle=45deg, total=8)  # copies kept: 7
  PhaseC2 [vacuum] = PhaseC1.duplicate_around_axis(axis=Z, angle=45deg, total=8)  # copies kept: 7
  [Stator, Rotor, PM1, PhaseA1, PhaseB1, PhaseC1, PhaseA2, PhaseB2, PhaseC2].split(plane=ZX, keep=PositiveOnly)
  [Stator, Rotor, PM1, PhaseA1, PhaseB1, PhaseC1, PhaseA2, PhaseB2, PhaseC2].rotate(axis=Z, angle=-45deg)
  [Stator, Rotor, PM1, PhaseA1, PhaseB1, PhaseC1, PhaseA2, PhaseB2, PhaseC2].split(plane=ZX, keep=NegativeOnly)
  [Stator, Rotor, PM1, PhaseA1, PhaseB1, PhaseC1, PhaseA2, PhaseB2, PhaseC2].rotate(axis=Z, angle=45deg)
  Region [vacuum] = polyline((0mm, 0mm, 0mm) (200mm, 0mm, 0mm))
  Region.sweep_around_axis(axis=Z, angle=45deg, segments=5)
  PM2 [N36Z_20, oriented by PM2_CS] = PM1.separate_bodies()
  coordinate_system PM1_CS = face of PM1: Origin=(64.799739, 41.119197, 0) FaceID=PM1.face(7 of 16) AxisPosn=(62.589074, 35.027944, 0) WhichAxis=X ZRotationAngle=0deg XOffset=0mm YOffset=0mm
  coordinate_system PM2_CS = face of PM2: Origin=(69.025655, 19.488662, 0) FaceID=PM1.face(16 of 16) AxisPosn=(74.895998, 16.744672, 0) WhichAxis=X ZRotationAngle=0deg XOffset=0mm YOffset=0mm
  Band [vacuum] = polyline((0mm, 0mm, 0mm) (80.575mm, 0mm, 0mm))
  Band.sweep_around_axis(axis=Z, angle=45deg)
  Band_in [vacuum] = polyline((0mm, 0mm, 0mm) (80.4mm, 0mm, 0mm))
  Band_in.sweep_around_axis(axis=Z, angle=45deg)
  Rotor2 [M19_29G] = polyline((78.72mm, 0mm, 0mm) (80.2mm, 0mm, 0mm))
  Rotor2.sweep_around_axis(axis=Z, angle=45deg)
  Rotor3 [M19_29G] = polyline((78.72mm, 0mm, 0mm) (79.46mm, 0mm, 0mm))
  Rotor3.sweep_around_axis(axis=Z, angle=45deg)
motion:
  MotionSetup1: Band Move_Type=Rotate Coordinate_System=Global Axis=Z Is_Positive=true InitPos=30deg Angular_Velocity=3000rpm Objects=Band
  Moving1: Moving Objects=[Rotor, PM1, PM2, Band_in, Rotor2, Rotor3]
boundaries and excitations:
  Independent1: Independent Edges=Region.edge(1 of 1)
  Dependent1: Dependent Edges=Region.edge(#2142) ReverseU Independent=Independent1 SameAsMaster=false
  Zero_Flux: Vector Potential Edges=Region.edge(#2136, #2137, #2138, #2139, #2140, #2141) Value=0
  Independent2: Independent Edges=Band.edge(1 of 1)
  Independent3: Independent Edges=Band_in.edge(1 of 1)
  PhaseA1: Coil Objects=PhaseA1 Conductor_number=9 Winding=Phase_A PolarityType=Positive
  PhaseA2: Coil Objects=PhaseA2 Conductor_number=9 Winding=Phase_A PolarityType=Positive
  PhaseB1: Coil Objects=PhaseB1 Conductor_number=9 Winding=Phase_B PolarityType=Positive
  PhaseB2: Coil Objects=PhaseB2 Conductor_number=9 Winding=Phase_B PolarityType=Positive
  PhaseC1: Coil Objects=PhaseC1 Conductor_number=9 Winding=Phase_C PolarityType=Negative
  PhaseC2: Coil Objects=PhaseC2 Conductor_number=9 Winding=Phase_C PolarityType=Negative
  Phase_A: Winding Group Type=Current IsSolid=false Current=Imax*sin(Omega_rad*Time+Thet) ParallelBranchesNum=1
  Phase_B: Winding Group Type=Current IsSolid=false Current=Imax*sin(Omega_rad*Time-2*pi/3+Thet) ParallelBranchesNum=1
  Phase_C: Winding Group Type=Current IsSolid=false Current=Imax*sin(Omega_rad*Time+2*pi/3+Thet) ParallelBranchesNum=1
  core loss on: Stator, Rotor, Rotor2, Rotor3
mesh:
  Coils: LengthBased RefineInside Objects=[PhaseA1, PhaseA2, PhaseB1, PhaseB2, PhaseC1, PhaseC2] MaxLength=4mm
  Magnets: LengthBased RefineInside Objects=[PM1, PM2] MaxLength=3mm
  Rotor: LengthBased RefineInside Objects=Rotor MaxLength=4mm
  Stator: LengthBased RefineInside Objects=Stator MaxLength=4mm
  CylindricalGap1: CylindricalGap Objects=Band
  initial mesh: MeshMethod=AnsoftTAU
setups:
  Setup1: Transient NonlinearSolverResidual=1e-06 StopTime=15ms TimeStep=250us SaveFieldsType="Every N Steps" N_Steps=1 Steps_From=0s Steps_To=15ms NumberSolveSteps=1 RangeStart=0s RangeEnd=0.1s InitialTimeStep=0.002s MinTimeStep=0.001s MaxTimeStep=0.003s TimeStepErrTolerance=0.0001
